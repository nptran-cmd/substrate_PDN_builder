; =============================================================================
; File: full_27layer_apd_implementer_batch.il
; Agent 04 (PDN Architect) — Stage 4 Full 27-Layer APD / Allegro Master Implementer
;
; Purpose:
;   Ingests the pipe-delimited Master Recipe (`U7_27Layer_APD_Master_Recipe.txt`)
;   generated by `apd_27layer_master_exporter.py` and instantiates every single
;   physical PDN object across all 27 conductor layers (`SURFACE` L01 to `BASE` L27)
;   inside Cadence Allegro Package Designer (APD 25.1 / `.mcm`):
;     1. `LSC_SYM`    : 254x `0201` LSC symbols on `BASE` (`BOTTOM`) in 8 Empty BGA Pockets
;                       using `axlCopyObject` + `axlTransformObject` from template `SM0201S`
;     2. `PLANE`      : 24x Inner-Layer Copper Planes (`12F`..`12B`) + `PLANE_VOID` (`eDTC` KOZs)
;     3. `VIA`        : 166,223x Stacked & Transition Vias across all 26 dielectric spans
;     4. `CLINE`      : 7,169x Electrical Connect-Line (`CLINE`) Transition Straps (`4FCO`, `6B`, `SURFACE`)
; =============================================================================

procedure( pdnBuildNetLookupTable()
  let( (d netTbl n)
    d = axlDBGetDesign()
    netTbl = makeTable("pdnMasterNetTbl" nil)
    when( d
      foreach( n d->nets
        when( n->name
          netTbl[n->name] = n
          netTbl[upperCase(n->name)] = n
        )
      )
    )
    netTbl
  )
)

procedure( pdnGetOrMakeNetDbid(netTbl netNameStr)
  let( (netId)
    netId = netTbl[netNameStr]
    unless( netId
      netId = netTbl[upperCase(netNameStr)]
    )
    unless( netId
      netId = axlDBCreateNet(netNameStr)
      when( netId
        netTbl[netNameStr] = netId
        netTbl[upperCase(netNameStr)] = netId
      )
    )
    netId
  )
)

procedure( pdnGetOrLoadPadstackName(padTbl padNameStr)
  let( (resolved psObj)
    resolved = padTbl[padNameStr]
    unless( resolved
      psObj = axlLoadPadstack(padNameStr)
      if( psObj then
        resolved = padNameStr
        padTbl[padNameStr] = resolved
      else
        if( rexMatchp("2FCI_2BCI" upperCase(padNameStr)) then
          psObj = axlLoadPadstack("V282_5_150_282_5_2FCI_2BCI_01B")
          when( psObj
            resolved = "V282_5_150_282_5_2FCI_2BCI_01B"
            padTbl[padNameStr] = resolved
          )
        )
      )
    )
    resolved
  )
)

procedure( pdnResolveConductorSubclass(subTbl rawSub)
  let( (u found)
    u = upperCase(rawSub)
    if( u == "TOP" then u = "SURFACE" )
    if( u == "BOTTOM" then u = "BASE" )
    found = subTbl[u]
    unless( found
      found = u
    )
    found
  )
)

procedure( pdnFindTemplateLscAndCleanU7Base()
  let( (d srcSym syms s sName sLyr sx sy u7Removed)
    d = axlDBGetDesign()
    srcSym = nil
    u7Removed = 0
    when( d
      syms = d->symbols
      foreach( s syms
        sName = if( s->name then upperCase(s->name) else "" )
        sLyr  = if( s->layer then upperCase(s->layer) else "" )
        when( rexMatchp("SM0201" sName) && (rexMatchp("BASE" sLyr) || rexMatchp("BOTTOM" sLyr))
          sx = if( s->xy then float(car(s->xy)) else 0.0 )
          sy = if( s->xy then float(cadr(s->xy)) else 0.0 )
          if( sx < 0.0 && srcSym == nil && (s->rotation == nil || abs(float(s->rotation)) < 1.0) then
            srcSym = s
          else
            when( sx >= 13000.0 && sx <= 35500.0 && sy >= -4000.0 && sy <= 36000.0
              errset(axlDeleteObject(s) nil)
              u7Removed = u7Removed + 1
            )
          )
        )
      )
    )
    printf("[Agent04-APD] Template 0201 LSC Symbol = %L | Cleared %d partial U7 BASE LSCs.\n"
      if( srcSym then srcSym->refdes else "NONE") u7Removed)

    ; Also clear any pre-existing VDDUC0 / VSS vias & clines in U7_EXT_BBOX (preserving C0 EMIB vias)
    let( (delList obj nName seStr)
      delList = nil
      axlClearSelSet()
      axlSetFindFilter(?enabled list("NOALL" "VIAS" "CLINES") ?onButtons list("NOALL" "VIAS" "CLINES"))
      axlAddSelectBox(list(list(13500.0 -3800.0) list(35200.0 35800.0)))
      foreach( obj axlGetSelSet()
        nName = if( obj->net && obj->net->name then upperCase(obj->net->name) else "" )
        when( nName == "VDDUC0" || nName == "VSS"
          seStr = if( obj->objType == "via" && obj->startEnd then upperCase(sprintf(nil "%L" obj->startEnd)) else "" )
          unless( rexMatchp("C0" seStr)
            delList = cons(obj delList)
          )
        )
      )
      axlClearSelSet()
      when( delList
        errset(axlDeleteObject(delList) nil)
      )
      printf("[Agent04-APD] Cleared %d pre-existing U7 VDDUC0/VSS vias & clines before clean 27-layer build.\n" length(delList))
    )

    srcSym
  )
)

procedure( pdnU7ParsePolyVerts( vertStr )
  let( (pairs p xy x y pts firstPt)
    pts = nil
    firstPt = nil
    foreach( p parseString(vertStr ";")
      xy = parseString(p ",")
      when( length(xy) >= 2
        x = float(atof(nth(0 xy)))
        y = float(atof(nth(1 xy)))
        unless( firstPt firstPt = list(x y) )
        pts = append1(pts list(x y))
      )
    )
    when( firstPt && length(pts) >= 3
      pts = append1(pts firstPt)
    )
    pts
  )
)

procedure( pdnU7CreatePolyRing( outerPts innerPts targetLayer )
  let( (oShp)
    when( outerPts && length(outerPts) >= 4
      oShp = car(errset(axlDBCreateOpenShape(axlPathStart(outerPts 0.0) t targetLayer nil) nil))
      when( oShp
        when( innerPts && length(innerPts) >= 4
          errset(axlDBCreateVoid(oShp axlPathStart(innerPts 0.0)) nil)
        )
        errset(axlDBCreateCloseShape(oShp) nil)
      )
    )
  )
)

; -----------------------------------------------------------------------------
; Stream-Execute the Full 27-Layer Pipe-Delimited Master Recipe File in APD
; -----------------------------------------------------------------------------
procedure( pdnImplementFull27LayerFromMasterRecipe(recipePath @optional (saveAtEnd t) (reportPath nil))
  let( (inPort line parts recType netTbl padTbl subTbl openPlaneTbl subs s
        srcSym srcX srcY copiedSyms
        symCount planeCount voidCount viaCount clineCount errCount
        refDes symName xVal yVal rotVal dx dy
        subName netName x1Val y1Val x2Val y2Val hasVoids
        rPath oShape netId padName wVal lyrSub repPort)

    ; Disable online DRC & dynamic fill during high-speed batch creation (173,670 objects)
    errset(axlDBControl('drcEnable nil) nil)
    errset(axlDBControl('dynamicFillMode 'disabled) nil)
    unless( axlIsLayer("SUBSTRATE GEOMETRY/recess_cavity_pdn")
      axlLayerCreateNonConductor("SUBSTRATE GEOMETRY/recess_cavity_pdn")
    )
    unless( axlIsLayer("SUBSTRATE GEOMETRY/LSC_CAVITY")
      axlLayerCreateNonConductor("SUBSTRATE GEOMETRY/LSC_CAVITY")
    )

    netTbl = pdnBuildNetLookupTable()
    padTbl = makeTable("pdnMasterPadTbl" nil)
    subTbl = makeTable("pdnMasterSubTbl" nil)
    openPlaneTbl = makeTable("pdnOpenPlaneTbl" nil)

    subs = axlSubclasses("CONDUCTOR")
    foreach( s subs
      subTbl[s] = s
      subTbl[upperCase(s)] = s
    )

    srcSym = pdnFindTemplateLscAndCleanU7Base()
    srcX = if( srcSym && srcSym->xy then float(car(srcSym->xy)) else 0.0 )
    srcY = if( srcSym && srcSym->xy then float(cadr(srcSym->xy)) else 0.0 )

    symCount   = 0
    planeCount = 0
    voidCount  = 0
    viaCount   = 0
    clineCount = 0
    errCount   = 0

    inPort = infile(recipePath)
    if( !inPort then
      printf("[Agent04-APD-ERR] Cannot open Master Recipe file: %s\n" recipePath)
      nil
    else
      printf("[Agent04-APD] Streaming Full 27-Layer Master Recipe: %s\n" recipePath)
      while( gets(line inPort)
        line = car(parseString(line "\r\n"))
        when( line && strlen(line) > 0 && substring(line 1 1) != "#"
          parts = parseString(line "|")
          recType = upperCase(nth(0 parts))

          case( recType
            ; POLY_CAVITY|<id>|<cav_verts>|<outer_koz_verts>|<inner_safe_verts>
            ("POLY_CAVITY"
              when( length(parts) >= 3
                let( (cavPts kozPts safePts rLyr)
                  rLyr    = "SUBSTRATE GEOMETRY/recess_cavity_pdn"
                  cavPts  = pdnU7ParsePolyVerts(nth(2 parts))
                  kozPts  = if( length(parts) >= 4 then pdnU7ParsePolyVerts(nth(3 parts)) else nil )
                  safePts = if( length(parts) >= 5 then pdnU7ParsePolyVerts(nth(4 parts)) else nil )
                  when( cavPts && length(cavPts) >= 4
                    errset(axlDBCreateShape(axlPathStart(cavPts 0.0) t "SUBSTRATE GEOMETRY/LSC_CAVITY") nil)
                    errset(axlDBCreatePath(axlPathStart(cavPts 25.0) rLyr) nil)
                  )
                  when( kozPts && length(kozPts) >= 4 && cavPts && length(cavPts) >= 4
                    pdnU7CreatePolyRing(kozPts cavPts rLyr)
                    errset(axlDBCreatePath(axlPathStart(kozPts 25.0) rLyr) nil)
                    when( axlIsLayer("ROUTE KEEPOUT/BASE")
                      errset(axlDBCreateShape(axlPathStart(kozPts 0.0) t "ROUTE KEEPOUT/BASE") nil)
                    )
                  )
                  when( safePts && length(safePts) >= 4 && cavPts && length(cavPts) >= 4
                    pdnU7CreatePolyRing(cavPts safePts rLyr)
                    errset(axlDBCreatePath(axlPathStart(safePts 20.0) rLyr) nil)
                  )
                )
              )
            )

            ; LSC_SYM|<refdes>|<symbol_name>|BOTTOM|<x>|<y>|<rot>|<pin1_net>|<pin2_net>|<pocket_id>
            ("LSC_SYM"
              when( length(parts) >= 9
                let( (p1Net p2Net devType devClass plcRes newSym pins p1Obj p2Obj)
                  axlSetVariable("logic_edit_enabled" t)
                  refDes  = nth(1 parts)
                  symName = nth(2 parts)
                  xVal    = float(atof(nth(4 parts)))
                  yVal    = float(atof(nth(5 parts)))
                  rotVal  = float(atof(nth(6 parts)))
                  p1Net   = nth(7 parts)
                  p2Net   = nth(8 parts)
                  pdnGetOrMakeNetDbid(netTbl p1Net)
                  pdnGetOrMakeNetDbid(netTbl p2Net)

                  let( (cwd dp devFile)
                    cwd = or(axlGetVariable("cwd") ".")
                    devType = strcat("LSC_DEV_" symName)
                    devFile = strcat(cwd "/" devType ".txt")
                    unless( isFile(devFile)
                      let( (dfp)
                        dfp = outfile(devFile "w")
                        when( dfp
                          fprintf(dfp "(DEVICE FILE: %s)\nPACKAGE %s\nCLASS DISCRETE\nPINCOUNT 2\nEND\n" devType symName)
                          close(dfp)
                        )
                      )
                    )
                    dp = or(axlGetVariable("devpath") ".")
                    unless( rexMatchp(cwd dp) axlSetVariable("devpath" strcat(cwd " " dp)) )
                  )
                  devClass = "DISCRETE"

                  errset(axlDBCreateComponent(refDes devType symName devClass) nil)
                  plcRes = errset(axlDBCreateSymbol(refDes list(xVal yVal) nil rotVal) nil)
                  newSym = if( plcRes && car(plcRes) then
                             if( listp(car(plcRes)) then car(car(plcRes)) else car(plcRes) )
                           else nil )
                  when( newSym && newSym->pins
                    let( (se0)
                      se0 = if( car(newSym->pins)->startEnd then upperCase(sprintf(nil "%L" car(newSym->pins)->startEnd)) else "" )
                      unless( rexMatchp("BASE" se0) || rexMatchp("BOTTOM" se0)
                        errset(axlDeleteObject(newSym) nil)
                        plcRes = errset(axlDBCreateSymbol(refDes list(xVal yVal) t rotVal) nil)
                        newSym = if( plcRes && car(plcRes) then
                                   if( listp(car(plcRes)) then car(car(plcRes)) else car(plcRes) )
                                 else nil )
                      )
                    )
                  )
                  unless( newSym
                    when( srcSym
                      dx = xVal - srcX
                      dy = yVal - srcY
                      copiedSyms = car(errset(axlCopyObject(srcSym ?move list(dx dy)) nil))
                      when( copiedSyms && abs(rotVal) > 0.1
                        errset(axlTransformObject(copiedSyms ?angle rotVal ?origin list(xVal yVal)) nil)
                      )
                      newSym = if( listp(copiedSyms) then car(copiedSyms) else copiedSyms )
                    )
                  )
                  if( newSym then
                    symCount = symCount + 1
                    when( newSym->pins && length(newSym->pins) >= 2
                      pins  = newSym->pins
                      p1Obj = nth(0 pins)
                      p2Obj = nth(1 pins)
                      foreach( p pins
                        when( p->number == "1" p1Obj = p )
                        when( p->number == "2" p2Obj = p )
                      )
                      errset(axlChangeNet(p1Obj p1Net) nil)
                      errset(axlChangeNet(p2Obj p2Net) nil)
                    )
                  else
                    errCount = errCount + 1
                  )
                )
              )
            )

            ; PLANE|<subclass>|<net_name>|<x1>|<y1>|<x2>|<y2>|<YES/NO>
            ("PLANE"
              when( length(parts) >= 8
                ; Close any previous open shape before opening the next layer's plane
                foreach( k openPlaneTbl
                  when( openPlaneTbl[k]
                    errset(axlDBCreateCloseShape(openPlaneTbl[k]) nil)
                    openPlaneTbl[k] = nil
                  )
                )
                subName  = pdnResolveConductorSubclass(subTbl nth(1 parts))
                netName  = nth(2 parts)
                x1Val    = float(atof(nth(3 parts)))
                y1Val    = float(atof(nth(4 parts)))
                x2Val    = float(atof(nth(5 parts)))
                y2Val    = float(atof(nth(6 parts)))
                hasVoids = upperCase(nth(7 parts))
                netId    = pdnGetOrMakeNetDbid(netTbl netName)
                lyrSub   = strcat("CONDUCTOR/" subName)

                rPath = axlPathStart(
                  list(
                    list(x1Val y1Val)
                    list(x2Val y1Val)
                    list(x2Val y2Val)
                    list(x1Val y2Val)
                    list(x1Val y1Val)
                  )
                )
                if( hasVoids == "YES" then
                  oShape = car(errset(axlDBCreateOpenShape(rPath t lyrSub netId) nil))
                  when( oShape
                    openPlaneTbl[subName] = oShape
                  )
                else
                  errset(axlDBCreateShape(rPath t lyrSub netId) nil)
                )
                planeCount = planeCount + 1
              )
            )

            ; PLANE_VOID|<subclass>|<void_name>|<vx1>|<vy1>|<vx2>|<vy2>
            ("PLANE_VOID"
              when( length(parts) >= 7
                subName = pdnResolveConductorSubclass(subTbl nth(1 parts))
                x1Val   = float(atof(nth(3 parts)))
                y1Val   = float(atof(nth(4 parts)))
                x2Val   = float(atof(nth(5 parts)))
                y2Val   = float(atof(nth(6 parts)))
                oShape  = openPlaneTbl[subName]
                when( oShape
                  rPath = axlPathStart(
                    list(
                      list(x1Val y1Val)
                      list(x2Val y1Val)
                      list(x2Val y2Val)
                      list(x1Val y2Val)
                      list(x1Val y1Val)
                    )
                  )
                  errset(axlDBCreateVoid(oShape rPath) nil)
                  voidCount = voidCount + 1
                )
              )
            )

            ; VIA|<net_name>|<padstack_name>|<start_layer>|<end_layer>|<x>|<y>|<zone_tag>
            ("VIA"
              when( length(parts) >= 7
                netName = nth(1 parts)
                padName = pdnGetOrLoadPadstackName(padTbl nth(2 parts))
                xVal    = float(atof(nth(5 parts)))
                yVal    = float(atof(nth(6 parts)))
                netId   = pdnGetOrMakeNetDbid(netTbl netName)
                if( padName then
                  if( netId then
                    axlDBCreateVia(padName list(xVal yVal) netId)
                  else
                    axlDBCreateVia(padName list(xVal yVal))
                  )
                  viaCount = viaCount + 1
                  when( mod(viaCount 25000) == 0
                    printf("[Agent04-APD] Progress: %d vias created...\n" viaCount)
                  )
                else
                  errCount = errCount + 1
                )
              )
            )

            ; CLINE|<net_name>|<layer>|<width_um>|<x1>|<y1>|<x2>|<y2>|<zone_tag>
            ("CLINE"
              when( length(parts) >= 8
                netName = nth(1 parts)
                subName = pdnResolveConductorSubclass(subTbl nth(2 parts))
                wVal    = float(atof(nth(3 parts)))
                x1Val   = float(atof(nth(4 parts)))
                y1Val   = float(atof(nth(5 parts)))
                x2Val   = float(atof(nth(6 parts)))
                y2Val   = float(atof(nth(7 parts)))
                netId   = pdnGetOrMakeNetDbid(netTbl netName)
                lyrSub  = strcat("CONDUCTOR/" subName)
                rPath   = axlPathStart(list(list(x1Val y1Val)) wVal)
                axlPathLine(rPath wVal list(x2Val y2Val))
                if( netId then
                  axlDBCreatePath(rPath lyrSub netId)
                else
                  axlDBCreatePath(rPath lyrSub)
                )
                clineCount = clineCount + 1
              )
            )
          )
        )
      )
      close(inPort)

      ; Close any open plane shapes that had eDTC cavity voids punched
      foreach( k openPlaneTbl
        when( openPlaneTbl[k]
          errset(axlDBCreateCloseShape(openPlaneTbl[k]) nil)
        )
      )

      printf("[Agent04-APD-DONE] Instantiated %d LSC Symbols, %d Planes (%d eDTC Voids), %d Vias, %d CLINEs (Errors=%d).\n"
        symCount planeCount voidCount viaCount clineCount errCount)

      when( saveAtEnd
        printf("[Agent04-APD] Saving design %s ...\n" axlCurrentDesign())
        axlSaveDesign(?design axlCurrentDesign() ?noConfirm t)
        printf("[Agent04-APD] Saved design %s successfully.\n" axlCurrentDesign())
      )

      when( reportPath
        repPort = outfile(reportPath "w")
        when( repPort
          fprintf(repPort "STATUS=SUCCESS\n")
          fprintf(repPort "DESIGN=%s\n" axlCurrentDesign())
          fprintf(repPort "LSC_SYMBOLS_CREATED=%d\n" symCount)
          fprintf(repPort "PLANES_CREATED=%d\n" planeCount)
          fprintf(repPort "PLANE_VOIDS_CREATED=%d\n" voidCount)
          fprintf(repPort "VIAS_CREATED=%d\n" viaCount)
          fprintf(repPort "CLINES_CREATED=%d\n" clineCount)
          fprintf(repPort "ERRORS=%d\n" errCount)
          close(repPort)
        )
      )

      list(symCount planeCount voidCount viaCount clineCount errCount)
    )
  )
)
